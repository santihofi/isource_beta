* PEX produced on Thu Sep 17 01:07:11 PM CEST 2026 using /foss/tools/sak/sak-pex.sh with m=3 and s=1 (extresist threshold=10000 mOhm, minres=1000 mOhm, mindelay=1 ps)
* NGSPICE file created from isource_beta_pex.ext - technology: ihp-sg13cmos5l

.subckt isource_beta_pex b0 vdd b1 out b2 b3 vss b4
X0 a_5865_6917# b4 a_315_6917# vss.t22 sg13_hv_nmos ad=1.52p pd=8.38u as=1.52p ps=8.38u w=8u l=0.45u
X1 a_6605_6917# a_6235_4831# vss.t18 rppd l=10u w=1u
X2 a_n122_54# a_122_n41# a_315_6917# vss.t43 sg13_hv_nmos ad=0.95p pd=5.38u as=0.95p ps=5.38u w=5u l=4u
X3 a_315_6917# a_122_n41# a_n122_54# vss.t42 sg13_hv_nmos ad=0.95p pd=5.38u as=0.95p ps=5.38u w=5u l=4u
X4 a_122_n41# a_122_n41# vss.t47 vss.t42 sg13_hv_nmos ad=0.95p pd=5.38u as=0.95p ps=5.38u w=5u l=4u
X5 a_10801_2932# vdd vdd vdd sg13_hv_pmos ad=0.34p pd=2.68u as=0.34p ps=2.68u w=1u l=10u
X6 a_315_6917# a_122_n41# a_n122_54# vss.t40 sg13_hv_nmos ad=0.95p pd=5.38u as=0.95p ps=5.38u w=5u l=4u
X7 vdd vdd vdd vdd sg13_hv_pmos ad=1.02p pd=6.68u as=70.6755p ps=0.17752m w=3u l=0.4u
X8 a_315_6917# a_122_n41# a_n122_54# vss.t44 sg13_hv_nmos ad=0.95p pd=5.38u as=0.95p ps=5.38u w=5u l=4u
X9 vss.t53 vss.t81 vss.t83 vss.t82 sg13_hv_nmos ad=0.95p pd=5.38u as=0 ps=0 w=5u l=0.45u
X10 a_315_6917# a_122_n41# a_n122_54# vss.t40 sg13_hv_nmos ad=0.95p pd=5.38u as=0.95p ps=5.38u w=5u l=4u
X11 vss.t49 vss.t57 vss.t72 vss.t61 sg13_hv_nmos ad=0.95p pd=5.38u as=0 ps=0 w=5u l=0.5u
X12 a_3645_6917# a_3275_4831# vss.t2 rppd l=10u w=1u
X13 a_5865_6917# a_6235_4831# vss.t95 rppd l=10u w=1u
X14 vss.t47 a_122_n41# a_122_n41# vss.t41 sg13_hv_nmos ad=0.95p pd=5.38u as=0.95p ps=5.38u w=5u l=4u
X15 a_n122_54# a_122_n41# a_315_6917# vss.t39 sg13_hv_nmos ad=0.95p pd=5.38u as=0.95p ps=5.38u w=5u l=4u
X16 a_9565_6917# a_9935_4831# vss.t67 rppd l=10u w=1u
X17 vdd a_n122_54# a_122_n41# vdd sg13_hv_pmos ad=0.57p pd=3.38u as=0.57p ps=3.38u w=3u l=4u
X18 vdd a_n122_54# a_122_n41# vdd sg13_hv_pmos ad=0.57p pd=3.38u as=0.57p ps=3.38u w=3u l=4u
X19 a_8955_3027# b2 a_8825_6917# vss.t92 sg13_hv_nmos ad=1.52p pd=8.38u as=1.52p ps=8.38u w=8u l=0.45u
X20 vss.t33 b0 a_8789_3027# vss.t32 sg13_hv_nmos ad=1.52p pd=8.38u as=1.52p ps=8.38u w=8u l=0.45u
X21 a_n122_54# a_n122_54# a_n122_54# vss.t63 sg13_hv_nmos ad=0.95p pd=5.38u as=0.14018n ps=0.33204m w=5u l=0.5u
X22 a_2905_6917# a_3275_4831# vss.t5 rppd l=10u w=1u
X23 vdd vdd vdd vdd sg13_hv_pmos ad=0.57p pd=3.38u as=0 ps=0 w=3u l=0.4u
X24 a_n122_54# a_n122_54# a_n122_54# vss.t62 sg13_hv_nmos ad=1.7p pd=10.68u as=0 ps=0 w=5u l=0.5u
X25 a_n122_54# a_n122_54# a_n122_54# vss.t60 sg13_hv_nmos ad=1.7p pd=10.68u as=0 ps=0 w=5u l=0.5u
X26 a_10801_2932# a_122_n41# vss.t51 vss.t50 sg13_hv_nmos ad=0.95p pd=5.38u as=0.95p ps=5.38u w=5u l=0.45u
X27 a_6605_6917# a_6975_4831# vss.t20 rppd l=10u w=1u
X28 a_9565_6917# a_9195_4831# vss.t34 rppd l=10u w=1u
X29 a_8955_3027# a_9935_4831# vss.t23 rppd l=10u w=1u
X30 a_8955_3027# b1 a_8789_3027# vss.t93 sg13_hv_nmos ad=1.52p pd=8.38u as=1.52p ps=8.38u w=8u l=0.45u
X31 a_122_n41# a_n122_54# vdd vdd sg13_hv_pmos ad=0.57p pd=3.38u as=0.57p ps=3.38u w=3u l=4u
X32 vdd a_n122_54# out vdd sg13_hv_pmos ad=0.57p pd=3.38u as=0.57p ps=3.38u w=3u l=4u
X33 a_n122_54# a_n122_54# a_n122_54# vss.t58 sg13_hv_nmos ad=1.7p pd=10.68u as=0 ps=0 w=5u l=0.5u
X34 vss.t57 vss.t57 vss.t57 vss.t61 sg13_hv_nmos ad=0.95p pd=5.38u as=0 ps=0 w=5u l=0.5u
X35 a_n122_54# a_n122_54# a_n122_54# vss.t59 sg13_hv_nmos ad=0.95p pd=5.38u as=0 ps=0 w=5u l=0.5u
X36 a_n122_54# a_n122_54# a_n122_54# vss.t61 sg13_hv_nmos ad=0.95p pd=5.38u as=0 ps=0 w=5u l=0.5u
X37 a_8825_6917# a_9195_4831# vss.t24 rppd l=10u w=1u
X38 vss.t47 a_122_n41# a_122_n41# vss.t41 sg13_hv_nmos ad=0.95p pd=5.38u as=0.95p ps=5.38u w=5u l=4u
X39 a_n122_54# a_122_n41# a_315_6917# vss.t39 sg13_hv_nmos ad=0.95p pd=5.38u as=0.95p ps=5.38u w=5u l=4u
X40 vdd a_n122_54# a_n122_54# vdd sg13_hv_pmos ad=0.57p pd=3.38u as=0.57p ps=3.38u w=3u l=4u
X41 a_n122_54# a_n122_54# a_n122_54# vss.t60 sg13_hv_nmos ad=1.7p pd=10.68u as=0 ps=0 w=5u l=0.5u
X42 vss.t49 a_122_n41# a_122_n41# vss.t43 sg13_hv_nmos ad=0.95p pd=5.38u as=0.95p ps=5.38u w=5u l=4u
X43 vss.t33 vss.t75 vss.t77 vss.t76 sg13_hv_nmos ad=1.52p pd=8.38u as=0 ps=0 w=8u l=0.45u
X44 a_122_n41# a_122_n41# vss.t46 vss.t40 sg13_hv_nmos ad=0.95p pd=5.38u as=0.95p ps=5.38u w=5u l=4u
X45 vss.t31 vss.t31 vss.t31 vss.t73 sg13_hv_nmos ad=2.72p pd=16.68u as=0 ps=0 w=8u l=0.45u
X46 a_315_6917# a_315_4831# vss.t8 rppd l=10u w=1u
X47 a_1425_6917# a_1055_4831# vss.t11 rppd l=10u w=1u
X48 a_3645_6917# a_4015_4831# vss.t4 rppd l=10u w=1u
X49 a_8955_3027# a_10675_4831# vss.t37 rppd l=10u w=1u
X50 a_n122_54# a_122_n41# a_315_6917# vss.t45 sg13_hv_nmos ad=0.95p pd=5.38u as=0.95p ps=5.38u w=5u l=4u
X51 a_7345_6917# a_7715_4831# vss.t16 rppd l=10u w=1u
X52 vdd a_n122_54# out vdd sg13_hv_pmos ad=0.57p pd=3.38u as=0.57p ps=3.38u w=3u l=4u
X53 vdd a_n122_54# a_n122_54# vdd sg13_hv_pmos ad=0.57p pd=3.38u as=0.57p ps=3.38u w=3u l=4u
X54 a_5865_6917# b3 a_8825_6917# vss.t28 sg13_hv_nmos ad=1.52p pd=8.38u as=1.52p ps=8.38u w=8u l=0.45u
X55 a_315_6917# a_122_n41# a_n122_54# vss.t38 sg13_hv_nmos ad=0.95p pd=5.38u as=0.95p ps=5.38u w=5u l=4u
X56 vss.t51 a_10801_2932# a_n122_54# vss.t66 sg13_hv_nmos ad=0.95p pd=5.38u as=0.95p ps=5.38u w=5u l=0.45u
X57 a_n122_54# a_n122_54# a_n122_54# vss.t63 sg13_hv_nmos ad=0.95p pd=5.38u as=0 ps=0 w=5u l=0.5u
X58 a_685_6917# a_1055_4831# vss.t19 rppd l=10u w=1u
X59 a_122_n41# a_n122_54# vdd vdd sg13_hv_pmos ad=0.57p pd=3.38u as=0.57p ps=3.38u w=3u l=4u
X60 a_n122_54# a_n122_54# a_n122_54# vss.t63 sg13_hv_nmos ad=0.95p pd=5.38u as=0 ps=0 w=5u l=0.5u
X61 a_315_6917# a_122_n41# a_n122_54# vss.t44 sg13_hv_nmos ad=0.95p pd=5.38u as=0.95p ps=5.38u w=5u l=4u
X62 vss.t70 vss.t54 vss.t46 vss.t60 sg13_hv_nmos ad=1.7p pd=10.68u as=0 ps=0 w=5u l=0.5u
X63 a_8789_3027# b1 a_8955_3027# vss.t94 sg13_hv_nmos ad=1.52p pd=8.38u as=1.52p ps=8.38u w=8u l=0.45u
X64 a_4385_6917# a_4755_4831# vss.t6 rppd l=10u w=1u
X65 a_7345_6917# a_6975_4831# vss.t12 rppd l=10u w=1u
X66 a_n122_54# a_122_n41# a_315_6917# vss.t39 sg13_hv_nmos ad=0.95p pd=5.38u as=0.95p ps=5.38u w=5u l=4u
X67 vss.t57 a_122_n41# a_122_n41# vss.t43 sg13_hv_nmos ad=0.95p pd=5.38u as=0.95p ps=5.38u w=5u l=4u
X68 a_315_6917# a_122_n41# a_n122_54# vss.t38 sg13_hv_nmos ad=0.95p pd=5.38u as=0.95p ps=5.38u w=5u l=4u
X69 a_n122_54# a_n122_54# a_n122_54# vss.t62 sg13_hv_nmos ad=1.7p pd=10.68u as=0 ps=0 w=5u l=0.5u
X70 a_122_n41# a_122_n41# vss.t54 vss.t40 sg13_hv_nmos ad=0.95p pd=5.38u as=0.95p ps=5.38u w=5u l=4u
X71 a_n122_54# a_n122_54# a_n122_54# vss.t58 sg13_hv_nmos ad=1.7p pd=10.68u as=0 ps=0 w=5u l=0.5u
X72 a_n122_54# a_122_n41# a_315_6917# vss.t43 sg13_hv_nmos ad=0.95p pd=5.38u as=0.95p ps=5.38u w=5u l=4u
X73 a_n122_54# a_n122_54# a_n122_54# vss.t59 sg13_hv_nmos ad=0.95p pd=5.38u as=0 ps=0 w=5u l=0.5u
X74 a_685_6917# a_315_4831# vss.t17 rppd l=10u w=1u
X75 a_4385_6917# a_4015_4831# vss.t15 rppd l=10u w=1u
X76 a_1425_6917# a_1795_4831# vss.t13 rppd l=10u w=1u
X77 out a_n122_54# vdd vdd sg13_hv_pmos ad=0.57p pd=3.38u as=0.57p ps=3.38u w=3u l=4u
X78 vss.t80 vss.t75 vss.t65 vss.t78 sg13_hv_nmos ad=1.7p pd=10.68u as=0 ps=0 w=5u l=0.45u
X79 a_8789_3027# vss.t36 vss.t35 rppd l=10u w=1u
X80 a_n122_54# a_n122_54# a_n122_54# vss.t63 sg13_hv_nmos ad=0.95p pd=5.38u as=0 ps=0 w=5u l=0.5u
X81 a_315_6917# a_122_n41# a_n122_54# vss.t42 sg13_hv_nmos ad=0.95p pd=5.38u as=0.95p ps=5.38u w=5u l=4u
X82 a_315_6917# a_122_n41# a_n122_54# vss.t44 sg13_hv_nmos ad=0.95p pd=5.38u as=0.95p ps=5.38u w=5u l=4u
X83 a_n122_54# a_n122_54# vdd vdd sg13_hv_pmos ad=0.57p pd=3.38u as=0.57p ps=3.38u w=3u l=4u
X84 vss.t54 vss.t54 vss.t54 vss.t60 sg13_hv_nmos ad=1.7p pd=10.68u as=0 ps=0 w=5u l=0.5u
X85 vss.t53 a_122_n41# a_10801_2932# vss.t52 sg13_hv_nmos ad=0.95p pd=5.38u as=0.95p ps=5.38u w=5u l=0.45u
X86 vdd vdd vdd vdd sg13_hv_pmos ad=1.02p pd=6.68u as=0 ps=0 w=3u l=0.4u
X87 a_8789_3027# a_10675_4831# vss.t90 rppd l=10u w=1u
X88 a_2905_6917# a_2535_4831# vss.t14 rppd l=10u w=1u
X89 a_n122_54# a_122_n41# a_315_6917# vss.t45 sg13_hv_nmos ad=0.95p pd=5.38u as=0.95p ps=5.38u w=5u l=4u
X90 a_n122_54# a_n122_54# a_n122_54# vss.t58 sg13_hv_nmos ad=1.7p pd=10.68u as=0 ps=0 w=5u l=0.5u
X91 a_n122_54# a_n122_54# a_n122_54# vss.t59 sg13_hv_nmos ad=0.95p pd=5.38u as=0 ps=0 w=5u l=0.5u
X92 a_315_6917# a_122_n41# a_n122_54# vss.t38 sg13_hv_nmos ad=0.95p pd=5.38u as=0.95p ps=5.38u w=5u l=4u
X93 a_n122_54# a_122_n41# a_315_6917# vss.t45 sg13_hv_nmos ad=0.95p pd=5.38u as=0.95p ps=5.38u w=5u l=4u
X94 a_8825_6917# b3 a_5865_6917# vss.t29 sg13_hv_nmos ad=1.52p pd=8.38u as=1.52p ps=8.38u w=8u l=0.45u
X95 out a_n122_54# vdd vdd sg13_hv_pmos ad=0.57p pd=3.38u as=0.57p ps=3.38u w=3u l=4u
X96 a_2165_6917# a_2535_4831# vss.t3 rppd l=10u w=1u
X97 a_5125_6917# a_4755_4831# vss.t0 rppd l=10u w=1u
X98 vss.t89 vss.t89 vss.t88 rppd l=10u w=1u
X99 a_n122_54# a_n122_54# a_n122_54# vss.t62 sg13_hv_nmos ad=1.7p pd=10.68u as=0 ps=0 w=5u l=0.5u
X100 a_8825_6917# a_8455_4831# vss.t26 rppd l=10u w=1u
X101 a_8789_3027# b0 vss.t31 vss.t30 sg13_hv_nmos ad=1.52p pd=8.38u as=1.52p ps=8.38u w=8u l=0.45u
X102 a_n122_54# a_122_n41# a_315_6917# vss.t41 sg13_hv_nmos ad=0.95p pd=5.38u as=0.95p ps=5.38u w=5u l=4u
X103 a_2165_6917# a_1795_4831# vss.t1 rppd l=10u w=1u
X104 vdd vdd vdd vdd sg13_hv_pmos ad=1.02p pd=6.68u as=0 ps=0 w=3u l=0.4u
X105 a_n122_54# a_n122_54# a_n122_54# vss.t61 sg13_hv_nmos ad=0.95p pd=5.38u as=0 ps=0 w=5u l=0.5u
X106 a_n122_54# a_122_n41# a_315_6917# vss.t45 sg13_hv_nmos ad=0.95p pd=5.38u as=0.95p ps=5.38u w=5u l=4u
X107 a_n122_54# a_122_n41# a_315_6917# vss.t41 sg13_hv_nmos ad=0.95p pd=5.38u as=0.95p ps=5.38u w=5u l=4u
X108 a_5865_6917# a_5495_4831# vss.t96 rppd l=10u w=1u
X109 a_8085_6917# a_8455_4831# vss.t27 rppd l=10u w=1u
X110 a_n122_54# a_122_n41# a_315_6917# vss.t39 sg13_hv_nmos ad=0.95p pd=5.38u as=0.95p ps=5.38u w=5u l=4u
X111 a_315_6917# b4 a_5865_6917# vss.t21 sg13_hv_nmos ad=1.52p pd=8.38u as=1.52p ps=8.38u w=8u l=0.45u
X112 a_n122_54# a_n122_54# a_n122_54# vss.t59 sg13_hv_nmos ad=0.95p pd=5.38u as=0 ps=0 w=5u l=0.5u
X113 a_315_6917# a_122_n41# a_n122_54# vss.t38 sg13_hv_nmos ad=0.95p pd=5.38u as=0.95p ps=5.38u w=5u l=4u
X114 a_122_n41# a_122_n41# vss.t47 vss.t42 sg13_hv_nmos ad=0.95p pd=5.38u as=0.95p ps=5.38u w=5u l=4u
X115 vss.t10 vss.t10 vss.t9 rppd l=10u w=1u
X116 a_n122_54# a_n122_54# vdd vdd sg13_hv_pmos ad=0.57p pd=3.38u as=0.57p ps=3.38u w=3u l=4u
X117 a_315_6917# a_122_n41# a_n122_54# vss.t44 sg13_hv_nmos ad=0.95p pd=5.38u as=0.95p ps=5.38u w=5u l=4u
X118 a_5125_6917# a_5495_4831# vss.t7 rppd l=10u w=1u
X119 a_8085_6917# a_7715_4831# vss.t25 rppd l=10u w=1u
X120 a_n122_54# a_n122_54# a_n122_54# vss.t62 sg13_hv_nmos ad=1.7p pd=10.68u as=0 ps=0 w=5u l=0.5u
X121 vdd vdd vdd vdd sg13_hv_pmos ad=0.57p pd=3.38u as=0 ps=0 w=3u l=0.4u
X122 a_8825_6917# b2 a_8955_3027# vss.t91 sg13_hv_nmos ad=1.52p pd=8.38u as=1.52p ps=8.38u w=8u l=0.45u
X123 a_n122_54# a_10801_2932# vss.t65 vss.t64 sg13_hv_nmos ad=0.95p pd=5.38u as=0.95p ps=5.38u w=5u l=0.45u
X124 vdd vdd vdd vdd sg13_hv_pmos ad=0.57p pd=3.38u as=0 ps=0 w=3u l=0.4u
X125 a_n122_54# a_n122_54# a_n122_54# vss.t58 sg13_hv_nmos ad=1.7p pd=10.68u as=0 ps=0 w=5u l=0.5u
R0 vss.t78 vss.n1 8.09413
R1 vss.t93 vss.n23 55.834
R2 vss.n35 vss.t94 54.4419
R3 vss.t76 vss.n36 54.4419
R4 vss.n22 vss.t73 53.0498
R5 vss.t66 vss.n38 51.6577
R6 vss.t28 vss.n26 50.2655
R7 vss.t90 vss.n39 49.5695
R8 vss.n32 vss.t29 48.8734
R9 vss.n25 vss.t26 48.1774
R10 vss.t88 vss.n0 16.9981
R11 vss.t52 vss.n41 46.0892
R12 vss.t22 vss.n29 44.6971
R13 vss.n31 vss.t34 43.852
R14 vss.n29 vss.t21 43.305
R15 vss.n41 vss.t50 41.9129
R16 vss.t92 vss.n32 39.1286
R17 vss.n26 vss.t91 37.7365
R18 vss.n38 vss.t64 36.3444
R19 vss.t30 vss.n22 34.9523
R20 vss.t67 vss.n33 34.2563
R21 vss.t32 vss.n35 33.5602
R22 vss.n36 vss.t32 33.5602
R23 vss.t25 vss.n15 7.78491
R24 vss.n23 vss.t30 32.1681
R25 vss.n16 vss.t58 4.48569
R26 vss.t19 vss.n0 5.5806
R27 vss.n0 vss.t41 5.206
R28 vss.t24 vss.n27 29.9309
R29 vss.n0 vss.t95 5.99543
R30 vss.t15 vss.n20 0.968491
R31 vss.t91 vss.n25 29.3839
R32 vss.t37 vss.n1 29.1642
R33 vss.t16 vss.n0 6.52101
R34 vss.n37 vss.t37 28.5388
R35 vss.n33 vss.t92 27.9918
R36 vss.n0 vss.n14 0.3928
R37 vss.n28 vss.t24 27.2957
R38 vss.t13 vss.n12 4.55371
R39 vss.n17 vss.t8 4.69528
R40 vss.n0 vss.n12 2.81241
R41 vss.n0 vss.n11 1.73334
R42 vss.t21 vss.n28 23.8154
R43 vss.n42 vss.t52 23.6455
R44 vss.n0 vss.t6 8.78062
R45 vss.n34 vss.t67 22.9703
R46 vss.n30 vss.t22 22.4233
R47 vss.t82 vss.n42 22.2543
R48 vss.t64 vss.n37 20.8822
R49 vss.t61 vss.n4 8.09207
R50 vss.n0 vss.t12 8.99138
R51 vss.n19 vss.n0 8.707
R52 vss.t96 vss.n4 7.68234
R53 vss.t17 vss.n0 9.30251
R54 vss.n13 vss.t39 9.06671
R55 vss.t4 vss.n0 9.28464
R56 vss.n19 vss.t18 0.570334
R57 vss.t38 vss.n17 8.65938
R58 vss.t33 vss.t75 1.68526
R59 vss.t75 vss.t77 1.68794
R60 vss.n8 vss.t77 1.31023
R61 vss.n6 vss.t75 0.23358
R62 vss.t80 vss.n6 1.16744
R63 vss.t75 vss.t65 1.16496
R64 vss.n7 vss.t72 1.26124
R65 vss.n10 vss.t54 0.0927152
R66 vss.t27 vss.n18 7.39877
R67 vss.n18 vss.n0 10.6291
R68 vss.n24 vss.n0 17.0005
R69 vss.n27 vss.n0 17.0005
R70 vss.n31 vss.n0 17.0005
R71 vss.n34 vss.n0 17.0005
R72 vss.n37 vss.n0 17.0005
R73 vss.n40 vss.n0 17.0005
R74 vss.t60 vss.n11 7.50824
R75 vss.t9 vss.n16 7.26104
R76 vss.n0 vss.t5 9.1956
R77 vss.n0 vss.n16 1.84085
R78 vss.n39 vss.t66 15.4628
R79 vss.n0 vss.n17 0.372206
R80 vss.t50 vss.n40 15.3137
R81 vss.n0 vss.t23 15.1955
R82 vss.t11 vss.n13 8.71248
R83 vss.n0 vss.n4 1.15273
R84 vss.t34 vss.n30 13.3746
R85 vss.n14 vss.t3 8.17789
R86 vss.n0 vss.t62 7.74614
R87 vss.t7 vss.n0 7.6857
R88 vss.n0 vss.t0 7.56827
R89 vss.n0 vss.t43 7.03166
R90 vss.t26 vss.n24 9.04922
R91 vss.n15 vss.t63 5.55591
R92 vss.n7 vss.t57 0.128292
R93 vss.t70 vss.n10 2.79687
R94 vss.n10 vss.n2 0.0858482
R95 vss.t46 vss.t54 8.49149
R96 vss.t46 vss.n9 1.38767
R97 vss.n9 vss.n2 0.104535
R98 vss.n5 vss.t81 0.102495
R99 vss.n5 vss.t83 1.31729
R100 vss.n3 vss.n0 1.05878
R101 vss.t14 vss.n0 6.53711
R102 vss.t29 vss.n31 8.35317
R103 vss.n40 vss.t90 7.65711
R104 vss.n27 vss.t28 6.96106
R105 vss.t1 vss.n11 6.30531
R106 vss.t59 vss.n12 5.06979
R107 vss.n0 vss.n20 5.12386
R108 vss.n5 vss.t53 1.14999
R109 vss.n15 vss.n0 0.770346
R110 vss.n0 vss.t20 4.49809
R111 vss.t2 vss.n0 4.37623
R112 vss.t73 vss.n18 6.79233
R113 vss.n22 vss.n0 3.55435
R114 vss.n23 vss.n0 3.55435
R115 vss.n25 vss.n0 3.55435
R116 vss.n26 vss.n0 3.55435
R117 vss.n28 vss.n0 3.55435
R118 vss.n29 vss.n0 3.55435
R119 vss.n30 vss.n0 3.55435
R120 vss.n32 vss.n0 3.55435
R121 vss.n33 vss.n0 3.55435
R122 vss.n35 vss.n0 3.55435
R123 vss.n36 vss.n0 3.55435
R124 vss.n1 vss.n0 2.90805
R125 vss.n38 vss.n0 3.55435
R126 vss.n39 vss.n0 3.55435
R127 vss.n41 vss.n0 3.55435
R128 vss.t35 vss.t82 3.48078
R129 vss.t94 vss.n34 2.78472
R130 vss.n9 vss.t70 2.17077
R131 vss.n7 vss.t49 1.17896
R132 vss.t75 vss.t36 2.2505
R133 vss vss.t47 0.939937
R134 vss.t33 vss.n8 1.31089
R135 vss vss.n21 1.70577
R136 vss.t51 vss.t81 1.69721
R137 vss.t10 vss.n0 0.659795
R138 vss.n0 vss.t89 0.653749
R139 vss.n24 vss.t93 1.39261
R140 vss.t42 vss.n20 0.211876
R141 vss.n19 vss.t44 0.61003
R142 vss.t47 vss.t57 1.1255
R143 vss.t45 vss.n0 8.81357
R144 vss.t40 vss.n14 6.78332
R145 vss.n42 vss.n0 0.777753
R146 vss.t23 vss.t76 0.696556
R147 vss.n21 vss.t51 0.305308
R148 vss.n21 vss.t75 0.3005
R149 vss.t47 vss.n3 0.439963
R150 vss.n8 vss.n6 0.0712065
R151 vss.t35 vss.n0 47.3713
R152 vss.t36 vss.t31 3.44788
R153 vss.n3 vss.n2 1.56469
R154 vss.n13 vss.n0 1.02415
C0 a_1795_4831# a_122_n41# 0.01143f
C1 a_2905_4917# a_2535_4917# 0.22681f
C2 a_8789_3027# b2 0.03073f
C3 a_8955_3027# a_9935_4831# 0.01673f
C4 a_9565_6917# a_9935_4917# 0.0392f
C5 a_122_n41# b0 0.02963f
C6 a_5495_4831# a_4755_4831# 0.01725f
C7 a_122_n41# a_3275_4917# 0.02503f
C8 a_5865_6917# a_5865_4917# 0.09013f
C9 b4 b0 0.01555f
C10 a_5125_4917# a_5495_4917# 0.22681f
C11 a_315_6917# a_315_4831# 0.05773f
C12 a_1795_4831# a_n122_54# 0.01663f
C13 a_6975_4917# a_6975_4831# 0.03112f
C14 a_122_n41# a_5865_4917# 0.0119f
C15 a_315_6917# a_4385_4917# 0.15827f
C16 a_4015_4917# a_4385_4917# 0.22681f
C17 b0 a_n122_54# 0.01512f
C18 b3 vdd 0.09866f
C19 a_8955_3027# vdd 0.02028f
C20 a_6235_4831# a_5495_4831# 0.01725f
C21 a_2165_6917# a_2165_4917# 0.03964f
C22 a_122_n41# a_2535_4831# 0.03864f
C23 a_2535_4917# a_2165_4917# 0.22681f
C24 a_4385_6917# a_3645_6917# 0.01725f
C25 a_4755_4831# a_4755_4917# 0.03112f
C26 a_3275_4831# a_122_n41# 0.04845f
C27 a_122_n41# a_2535_4917# 0.0119f
C28 a_5865_6917# a_6235_4917# 0.53673f
C29 a_1795_4917# a_315_6917# 0.16606f
C30 a_4015_4831# a_4385_4917# 0.03112f
C31 a_315_6917# a_1055_4917# 0.18551f
C32 a_3645_4917# a_315_6917# 0.15827f
C33 a_315_4917# a_n55_4917# 0.22681f
C34 a_4385_6917# a_5125_6917# 0.01725f
C35 a_3645_4917# a_4015_4917# 0.22681f
C36 a_5125_6917# a_5125_4917# 0.03964f
C37 b0 a_10801_2932# 0.01118f
C38 b0 b2 0.01626f
C39 a_122_n41# a_6975_4831# 0.03356f
C40 a_315_6917# a_8789_3027# 0.04974f
C41 b3 b1 0.01409f
C42 a_8955_3027# b1 0.39241f
C43 a_11045_4917# a_10675_4831# 0.0143f
C44 a_315_6917# a_5495_4917# 0.15827f
C45 a_9935_4831# b1 0.01767f
C46 a_1425_6917# a_1425_4917# 0.03964f
C47 a_685_6917# a_1055_4917# 0.03964f
C48 b3 a_8825_6917# 0.35118f
C49 a_8955_3027# a_8825_6917# 1.56325f
C50 a_5865_6917# b3 0.34569f
C51 a_5865_6917# a_8955_3027# 0.10398f
C52 a_122_n41# a_4755_4831# 0.03399f
C53 a_315_6917# a_7715_4917# 0.13422f
C54 a_6605_6917# a_6975_4917# 0.0392f
C55 a_4015_4917# a_3645_6917# 0.03964f
C56 a_11045_4917# a_8789_3027# 0.23655f
C57 a_8085_6917# a_8455_4917# 0.0392f
C58 a_122_n41# b3 0.02325f
C59 a_5865_6917# a_6605_6917# 0.02798f
C60 vdd b1 0.10222f
C61 a_9935_4917# a_8789_3027# 0.15739f
C62 a_315_6917# a_7345_4917# 0.13299f
C63 a_8455_4831# a_8455_4917# 0.03112f
C64 a_315_6917# a_7715_4831# 0.0387f
C65 a_7715_4917# a_8085_4917# 0.22681f
C66 a_315_6917# a_6605_4917# 0.13245f
C67 b4 b3 0.30329f
C68 a_8955_3027# b4 0.02757f
C69 a_8825_6917# vdd 0.01827f
C70 a_122_n41# a_6235_4831# 0.03387f
C71 a_1795_4831# a_315_6917# 0.03831f
C72 a_8955_3027# a_9565_4917# 0.04229f
C73 a_10675_4917# a_11045_4917# 0.22681f
C74 a_5865_6917# a_8455_4917# 0.14731f
C75 a_5865_6917# vdd 0.01383f
C76 a_122_n41# a_1055_4831# 0.03864f
C77 a_9935_4917# a_10305_4917# 0.22681f
C78 a_11415_4917# a_11785_4917# 0.22681f
C79 b0 a_315_6917# 0.02307f
C80 a_122_n41# a_5495_4831# 0.02375f
C81 a_315_6917# a_3275_4917# 0.15827f
C82 b3 a_n122_54# 0.01559f
C83 out vdd 0.48415f
C84 a_7715_4831# a_8085_4917# 0.03112f
C85 a_122_n41# vdd 1.80589f
C86 a_685_4917# a_315_4917# 0.22681f
C87 a_1425_4917# a_1055_4831# 0.03112f
C88 a_8455_4831# b1 0.01767f
C89 a_7715_4917# a_7345_6917# 0.0392f
C90 a_8085_6917# a_8825_6917# 0.01755f
C91 b4 vdd 0.09352f
C92 a_8825_6917# b1 0.04114f
C93 a_5865_4917# a_315_6917# 0.15827f
C94 a_5125_4917# a_4755_4831# 0.03112f
C95 a_5865_6917# a_6975_4917# 0.15385f
C96 a_5865_6917# b1 0.03966f
C97 a_3645_6917# a_2905_6917# 0.01725f
C98 b3 b2 0.51602f
C99 a_8955_3027# b2 0.38526f
C100 a_122_n41# a_2905_4917# 0.0119f
C101 a_315_6917# a_2535_4831# 0.03751f
C102 a_122_n41# a_4755_4917# 0.0119f
C103 a_3275_4831# a_315_6917# 0.03751f
C104 a_315_6917# a_2535_4917# 0.15827f
C105 a_n122_54# vdd 23.8585f
C106 a_5865_6917# a_8825_6917# 1.38671f
C107 a_7345_4917# a_7345_6917# 0.0392f
C108 a_122_n41# b1 0.02116f
C109 a_122_n41# a_6975_4917# 0.01074f
C110 a_10675_4917# a_10675_4831# 0.0143f
C111 a_4015_4831# a_3275_4831# 0.01725f
C112 a_6235_4917# a_315_6917# 0.13968f
C113 a_315_6917# a_6975_4831# 0.03976f
C114 b4 b1 0.01373f
C115 a_5865_6917# a_122_n41# 0.01043f
C116 a_8825_4917# a_8455_4917# 0.22681f
C117 a_3275_4917# a_2905_6917# 0.03964f
C118 a_3645_4917# a_3645_6917# 0.03964f
C119 a_10801_2932# vdd 0.45017f
C120 vdd b2 0.09753f
C121 a_8789_3027# a_10305_4917# 0.11932f
C122 b4 a_8825_6917# 0.04557f
C123 a_1425_6917# a_685_6917# 0.01725f
C124 a_9565_4917# a_8825_6917# 0.52413f
C125 a_5865_6917# b4 0.34238f
C126 a_122_n41# a_2165_4917# 0.0119f
C127 a_122_n41# out 0.29412f
C128 a_10675_4917# a_8789_3027# 0.11943f
C129 a_5865_6917# a_9565_4917# 0.01139f
C130 a_315_6917# a_4755_4831# 0.03822f
C131 a_1795_4917# a_1795_4831# 0.03112f
C132 a_9195_4831# b3 0.02807f
C133 a_315_6917# a_315_4917# 0.68722f
C134 b4 a_122_n41# 0.01663f
C135 a_10675_4917# a_10305_4917# 0.22681f
C136 a_9195_4831# a_9935_4831# 0.01725f
C137 a_4015_4831# a_4755_4831# 0.01725f
C138 a_315_6917# b3 0.02905f
C139 a_8955_3027# a_315_6917# 0.05187f
C140 a_5125_6917# a_5495_4917# 0.03964f
C141 a_2165_6917# a_2905_6917# 0.01725f
C142 a_122_n41# a_1425_4917# 0.0119f
C143 a_3645_4917# a_3275_4917# 0.22681f
C144 b1 b2 0.72966f
C145 a_4385_6917# a_4755_4917# 0.03964f
C146 a_5125_4917# a_4755_4917# 0.22681f
C147 out a_n122_54# 2.35706f
C148 a_8955_3027# a_9565_6917# 0.02378f
C149 a_8825_4917# a_8455_4831# 0.03112f
C150 a_122_n41# a_n122_54# 15.4321f
C151 a_9195_4917# a_8825_6917# 0.25254f
C152 b0 a_8789_3027# 0.4226f
C153 a_6235_4831# a_315_6917# 0.03765f
C154 a_8825_4917# a_8825_6917# 0.06245f
C155 a_7345_4917# a_7715_4917# 0.22681f
C156 a_8825_6917# b2 0.37239f
C157 a_5865_6917# a_9195_4917# 0.22331f
C158 a_5865_6917# a_8825_4917# 0.15129f
C159 a_7715_4917# a_7715_4831# 0.03112f
C160 a_315_6917# a_1055_4831# 0.04013f
C161 a_5865_6917# b2 0.04263f
C162 b4 a_n122_54# 0.01522f
C163 a_315_6917# a_5495_4831# 0.03751f
C164 a_8955_3027# a_11045_4917# 0.07125f
C165 a_122_n41# a_685_4917# 0.0119f
C166 a_315_6917# a_8455_4917# 0.13994f
C167 a_315_6917# vdd 0.0268f
C168 a_122_n41# a_10801_2932# 0.43456f
C169 a_122_n41# b2 0.02247f
C170 a_8955_3027# a_9935_4917# 0.17316f
C171 a_3275_4831# a_3645_4917# 0.03112f
C172 a_1795_4917# a_1425_6917# 0.03964f
C173 a_5865_4917# a_5495_4917# 0.22681f
C174 a_9935_4831# a_9935_4917# 0.03272f
C175 a_9565_4917# a_9195_4917# 0.22681f
C176 b4 b2 0.01522f
C177 a_122_n41# a_5125_4917# 0.0119f
C178 a_315_6917# a_2905_4917# 0.15827f
C179 a_8085_4917# a_8455_4917# 0.22681f
C180 a_315_6917# a_4755_4917# 0.15827f
C181 a_315_6917# a_n55_4917# 0.02113f
C182 a_315_4917# a_315_4831# 0.03225f
C183 a_10801_2932# a_n122_54# 0.38228f
C184 a_n122_54# b2 0.01303f
C185 a_315_6917# b1 0.01872f
C186 a_315_6917# a_6975_4917# 0.13546f
C187 a_9195_4831# a_8455_4831# 0.01725f
C188 a_9195_4831# a_8825_6917# 0.03054f
C189 a_315_6917# a_8455_4831# 0.05514f
C190 a_6605_6917# a_7345_6917# 0.01725f
C191 a_5865_6917# a_9195_4831# 0.06079f
C192 a_315_6917# a_8825_6917# 0.13226f
C193 a_5865_6917# a_315_6917# 1.5995f
C194 a_8825_4917# a_9195_4917# 0.22681f
C195 a_9565_6917# a_8825_6917# 0.02832f
C196 a_315_4831# a_1055_4831# 0.01725f
C197 a_9935_4831# a_10675_4831# 0.01725f
C198 a_8085_6917# a_8085_4917# 0.0392f
C199 a_315_6917# a_2165_4917# 0.15827f
C200 a_1795_4831# a_2535_4831# 0.01725f
C201 a_11415_4917# a_11045_4917# 0.22681f
C202 a_122_n41# a_315_6917# 13.4991f
C203 a_122_n41# a_4015_4917# 0.0119f
C204 b4 a_9195_4831# 0.0181f
C205 a_8789_3027# b3 0.0271f
C206 a_8955_3027# a_8789_3027# 1.79239f
C207 a_5865_6917# a_8085_4917# 0.14494f
C208 a_7345_4917# a_6975_4831# 0.03112f
C209 a_9565_4917# a_9195_4831# 0.03751f
C210 a_3275_4831# a_3275_4917# 0.03112f
C211 a_9935_4831# a_8789_3027# 0.05208f
C212 b4 a_315_6917# 0.31031f
C213 a_1055_4917# a_1055_4831# 0.03112f
C214 a_7715_4831# a_6975_4831# 0.01725f
C215 a_6235_4917# a_6605_4917# 0.22681f
C216 a_4015_4831# a_122_n41# 0.0336f
C217 a_9565_4917# a_315_6917# 0.01382f
C218 a_2905_4917# a_2905_6917# 0.03964f
C219 a_9935_4917# a_8825_6917# 0.03255f
C220 a_315_6917# a_1425_4917# 0.17157f
C221 a_8085_6917# a_7345_6917# 0.01725f
C222 a_8955_3027# a_10305_4917# 0.22829f
C223 a_9565_4917# a_9565_6917# 0.03391f
C224 a_315_6917# a_n122_54# 6.47549f
C225 a_9935_4831# a_10305_4917# 0.0143f
C226 a_4755_4917# a_4385_4917# 0.22681f
C227 a_8955_3027# a_10675_4917# 0.56118f
C228 a_5495_4917# a_5495_4831# 0.03112f
C229 a_8789_3027# vdd 0.02323f
C230 a_3275_4831# a_2535_4831# 0.01725f
C231 a_2535_4831# a_2535_4917# 0.03112f
C232 a_315_6917# a_685_4917# 0.2473f
C233 a_9195_4831# a_9195_4917# 0.03549f
C234 a_2165_6917# a_2535_4917# 0.03964f
C235 a_315_6917# a_9195_4917# 0.07832f
C236 a_315_6917# a_8825_4917# 0.15319f
C237 a_6235_4917# a_5865_4917# 0.22681f
C238 a_1425_6917# a_2165_6917# 0.01725f
C239 a_315_6917# b2 0.03269f
C240 a_9565_4917# a_9935_4917# 0.22681f
C241 b0 b3 0.01578f
C242 a_8955_3027# b0 0.04478f
C243 a_6235_4831# a_6605_4917# 0.03112f
C244 a_315_6917# a_5125_4917# 0.15827f
C245 a_685_4917# a_685_6917# 0.03964f
C246 a_122_n41# a_315_4831# 0.03864f
C247 a_6605_6917# a_6605_4917# 0.0392f
C248 a_122_n41# a_4385_4917# 0.0119f
C249 a_8789_3027# b1 0.41844f
C250 a_1795_4831# a_1055_4831# 0.01725f
C251 a_11415_4917# a_8789_3027# 0.64374f
C252 a_8455_4831# a_8789_3027# 0.01034f
C253 a_1795_4917# a_2165_4917# 0.22681f
C254 a_8789_3027# a_8825_6917# 0.09164f
C255 a_1795_4917# a_122_n41# 0.0119f
C256 a_5865_6917# a_8789_3027# 0.08298f
C257 a_122_n41# a_1055_4917# 0.0119f
C258 a_5865_6917# a_5495_4917# 0.01176f
C259 a_122_n41# a_3645_4917# 0.02503f
C260 b0 vdd 0.10434f
C261 a_1795_4917# a_1425_4917# 0.22681f
C262 a_315_6917# a_9195_4831# 0.08125f
C263 a_685_4917# a_315_4831# 0.03112f
C264 a_5865_6917# a_7715_4917# 0.1464f
C265 a_122_n41# a_5495_4917# 0.0119f
C266 a_1425_4917# a_1055_4917# 0.22681f
C267 a_5865_4917# a_5495_4831# 0.03112f
C268 a_7345_4917# a_6975_4917# 0.22681f
C269 a_315_6917# a_4015_4917# 0.15827f
C270 b4 a_8789_3027# 0.02705f
C271 a_6975_4917# a_6605_4917# 0.22681f
C272 a_2905_4917# a_3275_4917# 0.22681f
C273 a_7715_4831# a_8455_4831# 0.01725f
C274 a_122_n41# a_7715_4917# 0.01095f
C275 a_5865_6917# a_7345_4917# 0.14652f
C276 a_4015_4831# a_315_6917# 0.03777f
C277 a_4015_4831# a_4015_4917# 0.03112f
C278 b0 b1 0.94624f
C279 a_5865_6917# a_5125_6917# 0.01755f
C280 a_6235_4917# a_6235_4831# 0.03112f
C281 a_6235_4831# a_6975_4831# 0.01725f
C282 a_685_4917# a_1055_4917# 0.22681f
C283 a_5865_6917# a_6605_4917# 0.20368f
C284 a_4385_6917# a_4385_4917# 0.03964f
C285 a_315_6917# a_8085_4917# 0.13575f
C286 a_315_6917# a_685_6917# 0.02635f
C287 b0 a_8825_6917# 0.042f
C288 a_122_n41# a_7345_4917# 0.01074f
C289 a_5865_6917# b0 0.04129f
C290 a_122_n41# a_7715_4831# 0.01856f
C291 a_122_n41# a_6605_4917# 0.01074f
C292 a_1795_4831# a_2165_4917# 0.03112f
C293 a_2535_4831# a_2905_4917# 0.03112f
C294 a_8955_3027# b3 0.03508f
C295 out vss 0.18756f
C296 a_8789_3027# vss 6.42293f
C297 a_10675_4831# vss 2.03723f
C298 a_8955_3027# vss 3.83683f
C299 a_9935_4831# vss 1.89877f
C300 a_9565_6917# vss 1.84924f
C301 a_9195_4831# vss 1.70975f
C302 a_8825_6917# vss 3.57253f
C303 a_8455_4831# vss 1.74519f
C304 a_8085_6917# vss 1.83645f
C305 a_7715_4831# vss 1.77555f
C306 a_7345_6917# vss 1.83632f
C307 a_6975_4831# vss 1.77201f
C308 a_6605_6917# vss 1.83632f
C309 a_6235_4831# vss 1.77168f
C310 a_5865_6917# vss 4.05382f
C311 a_5495_4831# vss 1.77478f
C312 a_5125_6917# vss 1.83699f
C313 a_4755_4831# vss 1.77168f
C314 a_4385_6917# vss 1.83699f
C315 a_4015_4831# vss 1.772f
C316 a_3645_6917# vss 1.83699f
C317 a_3275_4831# vss 1.76827f
C318 a_2905_6917# vss 1.83699f
C319 a_2535_4831# vss 1.76828f
C320 a_2165_6917# vss 1.83699f
C321 a_1795_4831# vss 1.77764f
C322 a_1425_6917# vss 1.83732f
C323 a_1055_4831# vss 1.76935f
C324 a_685_6917# vss 1.83908f
C325 a_315_4831# vss 1.80651f
C326 a_315_6917# vss 49.40339f
C327 vss.t51 vss 24.89333f
C328 vss.t36 vss 0.77587f
C329 vss.t33 vss 1.02576f
C330 vss.t89 vss 2.36991f
C331 vss.t10 vss 2.40906f
.ends
