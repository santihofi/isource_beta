** sch_path: /foss/designs/heichip/isource_beta/schematic/xschem/isource_beta.sch
.subckt isource_beta b0 vdd b1 out b2 b3 vss b4
*.PININFO out:O vdd:B vss:B b0:B b1:B b2:B b3:B b4:B
XM1 net1 v0 vdd vdd sg13_hv_pmos w=12u l=4u ng=4 m=1 mm_ok=1
XM2 v0 v0 vdd vdd sg13_hv_pmos w=12u l=4u ng=4 m=1 mm_ok=1
XM3 net1 net1 vss vss sg13_hv_nmos w=40u l=4u ng=8 m=1 mm_ok=1
XM4 v0 net1 iref vss sg13_hv_nmos w=40u l=4u ng=8 m=3 mm_ok=1
XM5 out v0 vdd vdd sg13_hv_pmos w=12u l=4u ng=4 m=1 mm_ok=1
XMS1 net2 vdd vdd vdd sg13_hv_pmos w=1u l=10u ng=1 m=1 mm_ok=1
XMS2 net2 net1 vss vss sg13_hv_nmos w=10u l=0.45u ng=2 m=1 mm_ok=1
XMS3 v0 net2 vss vss sg13_hv_nmos w=10u l=0.45u ng=2 m=1 mm_ok=1
XR10 iref net4 vss rppd w=1e-6 l=160e-6 m=1 b=0 mm_ok=1
XR2 net6 vss vss rppd w=1e-6 l=10e-6 m=1 b=0 mm_ok=1
XM6 iref b4 net4 vss sg13_hv_nmos w=16u l=0.45u ng=2 m=1 mm_ok=1
XR3 net5 net6 vss rppd w=1e-6 l=20e-6 m=1 b=0 mm_ok=1
XR4 net3 net5 vss rppd w=1e-6 l=40e-6 m=1 b=0 mm_ok=1
XR5 net4 net3 vss rppd w=1e-6 l=80e-6 m=1 b=0 mm_ok=1
XM7 net4 b3 net3 vss sg13_hv_nmos w=16u l=0.45u ng=2 m=1 mm_ok=1
XM8 net3 b2 net5 vss sg13_hv_nmos w=16u l=0.45u ng=2 m=1 mm_ok=1
XM9 net5 b1 net6 vss sg13_hv_nmos w=16u l=0.45u ng=2 m=1 mm_ok=1
XM10 net6 b0 vss vss sg13_hv_nmos w=16u l=0.45u ng=2 m=1 mm_ok=1
XM11 v0 v0 v0 vss sg13_hv_nmos w=100u l=0.5u ng=20 m=1 mm_ok=1
XM12 vss vss vss vss sg13_hv_nmos w=26u l=0.45u ng=4 m=1 mm_ok=1
XR1 vss vss vss rppd w=1e-6 l=10e-6 m=2 b=0 mm_ok=1
.ends
